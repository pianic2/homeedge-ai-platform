* IHAP-55 TPS63802 vendor-model transient: MP_SYS 5.184 V, 100 -> 500 mA
* Run from hardware/edge-mainboard/simulation after fetching the TI model.
.include vendor-models/TPS63802_TRANS.LIB
Vinput vin 0 PWL(0 0 0.1m 0 0.11m 5.184 5m 5.184)
Cin vin 0 10u
XU4 0 vin fb 0 sw1 sw2 0 pg vin out TPS63802_TRANS
Lpower sw1 sw2 0.47u
Cout1 out 0 22u
Cout2 out 0 22u
Rtop out fb 900k
Rbottom fb 0 100k
Rpg pg vin 100k
Ridle out 0 50
Istep out 0 PWL(0 0 2m 0 2.01m 0.4 3m 0.4 3.01m 0 5m 0)
.tran 1u 5m 0 100n
.meas tran vout_before AVG v(out) FROM=1.5m TO=1.9m
.meas tran vout_step_min MIN v(out) FROM=2m TO=3m
.meas tran vout_step_max MAX v(out) FROM=3m TO=4m
.meas tran vout_final AVG v(out) FROM=4.5m TO=4.9m
.end
